RC syntax-validation example
* No electrical simulation is performed.
V1 1 0 5
R1 1 2 1k
C1 2 0 1u IC=0
.TRAN 1u 1m
.PRINT TRAN V(2)
.END
